* overlap decomposition at vc=0.3 and 1.65
.include 'hdr.inc'
.include 'p0.inc'
.temp 27
vdd_src  vdd      0 3.3
vss_src  vss      0 0
ven      pll_en   0 3.3
vup      pfd_up   0 pulse(0 3.3 20n 100p 100p 1n 40n)
vdn      pfd_dn   0 pulse(0 3.3 20n 100p 100p 1n 40n)
vt0      cp_trim0 0 0
vt1      cp_trim1 0 0
vvc      vctrl    0 0.3
cload    vco_out  0 15f
xdut vco_out pfd_up pfd_dn pll_en cp_trim0 cp_trim1 vctrl bias_ref vdd vss pll_analog
.save all @m.xdut.xmp_ups.m0[id] @m.xdut.xmn_dns.m0[id]
.control
foreach vc 0.3 1.65
alter vvc dc = $vc
tran 10p 112n 0 10p
meas tran q1 integ i(vvc) from=99n to=100.05n
meas tran q2 integ i(vvc) from=100.05n to=100.4n
meas tran q3 integ i(vvc) from=100.4n to=101.1n
meas tran q4 integ i(vvc) from=101.1n to=101.5n
meas tran q5 integ i(vvc) from=101.5n to=111n
meas tran im avg i(vvc) from=100.6n to=101.0n
meas tran ius avg v(xdut.up_s) from=100.6n to=101.0n
meas tran ids avg v(xdut.dn_s) from=100.6n to=101.0n
meas tran iup avg @m.xdut.xmp_ups.m0[id] from=100.6n to=101.0n
meas tran idn avg @m.xdut.xmn_dns.m0[id] from=100.6n to=101.0n
meas tran vdm0 find v(xdut.vdump) at=99n
meas tran vus0 find v(xdut.up_s) at=99n
meas tran vds0 find v(xdut.dn_s) at=99n
destroy $curplot
end
.endc
.end
