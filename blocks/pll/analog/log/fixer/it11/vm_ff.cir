* pll_analog_vco_tb.cir - VCO tuning and output bench (spec.yaml:
* vco_kvco_mhz_per_v, vco_df_dv_min_mhz_per_v, vco_fmin_tt_mhz,
* vco_fmax_tt_mhz, vco_fmax_ff_mhz, vco_out_swing_pct_vdd, vco_out_tr_ns,
* vco_out_tf_ns, vco_out_duty_pct; vco_period_jitter_ps_rms is bounded in the
* sidecar but NOT printed - see JITTER below). Written from spec/ only.
*
* vctrl is forced by vvc; pump inputs low, pll_en = 1, bias_ref floating,
* vco_out into 15 fF. Operating-point-first .tran (no uic) per point.
*
* Sweep: vctrl = 0.3 V .. vdd-0.3 V in 12 equal steps (13 points; point 6 is
* exactly vdd/2). Per point: frequency = 5 / (time of the 6th minus the 1st
* rising vdd/2 crossing after 200 ns), window 1.2 us, so anything above
* ~5 MHz is resolved and a stalled ring prints no frequency at all.
*  - vco_kvco_mhz_per_v    = (f(vdd-0.3) - f(0.3)) / (vdd-0.6), the mean df/dv
*  - vco_df_dv_min_mhz_per_v = min over adjacent points of df/dv
*  - vco_fmin_tt_mhz / vco_fmax_tt_mhz = f(0.3 V) / f(vdd-0.3 V) (bounds at tt)
*  - vco_out_swing_pct_vdd = min over the sweep of (max-min of vco_out after
*    200 ns) / vdd * 100
*  - vco_out_duty_pct      = high time / period at vctrl = vdd/2, vdd/2 threshold
* Extra point vctrl = vdd (the maximum frequency, the prescaler's 333 MHz
* condition): vco_fmax_ff_mhz (bound at ff_m40c_vp10 only) and the 20-80 %
* rise/fall times vco_out_tr_ns / vco_out_tf_ns (bounds at ff_m40c_vp10, tt_27c),
* 5 ps max step.
* If any sweep point fails to oscillate, the sweep-derived measures are not
* printed (sim_measure_missing), never a placeholder.
*
* JITTER: vco_period_jitter_ps_rms needs device noise inside the ring during
* a transient. ngspice-47 has no device-level transient noise (only trnoise/
* trrandom on independent sources), and a bench cannot attach a noise source
* to the ring nodes r1..r5, which are internal to the subckt. The bound is kept
* in the sidecar so the spec measure stays declared; the bench prints nothing
* for it, so sim_tt reports it as a (warning) sim_measure_missing at tt_27c.
* sim_timeout_s: 900

.include '/home/ihsan/.cc/toolchains/iic-osic-tools-2026.09/foss/pdks/gf180mcuD/libs.tech/ngspice/design.spice'
.lib '/home/ihsan/.cc/toolchains/iic-osic-tools-2026.09/foss/pdks/gf180mcuD/libs.tech/ngspice/sm141064.spice' ff
.lib '/home/ihsan/.cc/toolchains/iic-osic-tools-2026.09/foss/pdks/gf180mcuD/libs.tech/ngspice/sm141064.spice' res_ff
.lib '/home/ihsan/.cc/toolchains/iic-osic-tools-2026.09/foss/pdks/gf180mcuD/libs.tech/ngspice/sm141064.spice' mimcap_ff
.include '/tmp/nl10/pll_analog.cir'
.param w_bp='4e-06' l_bp='2e-06' w_b1='2e-06' l_b1='2e-06' w_b2='4e-06' l_b2='1e-06' rb_l=0.00054 w_cpn='2e-05' l_cpn='2e-06' w_cpp='5e-05' l_cpp='2e-06' w_swn='2e-06' w_swp='4e-06' l_sw='5e-07' r1_l=0.000126 c1_w=0.0001 c2_w=3.2e-05 w_v2i='1e-05' l_v2i='1e-06' rv2i_l=5e-05 w_flr='2e-06' l_flr='2e-06' w_v2ip='1e-05' w_v2in='4e-06' l_v2i2='5e-07' w_sp='1e-05' w_sn='4e-06' l_s='5e-07' w_rp=6e-06 w_rn=3e-06 l_r=2.8e-07 w_gp='4e-06' w_gn='4e-06' w_op=1.2e-05 w_on='6e-06'

.temp -40
.param vddp=3.63
.csparam vddp={vddp}
.csparam vmid={vddp/2}
.csparam vhi={vddp-0.3}
.csparam v20={0.2*vddp}
.csparam v80={0.8*vddp}

vdd_src  vdd      0 {vddp}
vss_src  vss      0 0
ven      pll_en   0 {vddp}
vup      pfd_up   0 0
vdn      pfd_dn   0 0
vt0      cp_trim0 0 0
vt1      cp_trim1 0 0
vvc      vctrl    0 0.3
cload    vco_out  0 15f
xdut vco_out pfd_up pfd_dn pll_en cp_trim0 cp_trim1 vctrl bias_ref vdd vss pll_analog

.control
set noaskquit
foreach vc 0.3 3.0 3.63
  alter vvc dc = $vc
  tran 20p 600n 0 20p
  meas tran vx max v(vco_out) from=200n to=600n
  meas tran vn min v(vco_out) from=200n to=600n
  meas tran ta when v(vco_out)=1.815 rise=1 td=200n
  meas tran tb when v(vco_out)=1.815 rise=3 td=200n
  let f = 2/(tb-ta)/1e6
  echo "VCOF $vc f=$&f sw=$&vx $&vn"
  destroy $curplot
end
.endc
.end
