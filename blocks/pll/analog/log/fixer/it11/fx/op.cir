* op at 0.3
.include '/home/ihsan/.cc/toolchains/iic-osic-tools-2026.09/foss/pdks/gf180mcuD/libs.tech/ngspice/design.spice'
.lib '/home/ihsan/.cc/toolchains/iic-osic-tools-2026.09/foss/pdks/gf180mcuD/libs.tech/ngspice/sm141064.spice' typical
.lib '/home/ihsan/.cc/toolchains/iic-osic-tools-2026.09/foss/pdks/gf180mcuD/libs.tech/ngspice/sm141064.spice' res_typical
.lib '/home/ihsan/.cc/toolchains/iic-osic-tools-2026.09/foss/pdks/gf180mcuD/libs.tech/ngspice/sm141064.spice' mimcap_typical
.include '/tmp/it11/fx/nl.cir'
.temp 27
vdd_src vdd 0 3.3
vss_src vss 0 0
ven pll_en 0 3.3
vup pfd_up 0 0
vdn pfd_dn 0 0
vt0 cp_trim0 0 0
vt1 cp_trim1 0 0
vvc vctrl 0 0.3
cload vco_out 0 15f
xdut vco_out pfd_up pfd_dn pll_en cp_trim0 cp_trim1 vctrl bias_ref vdd vss pll_analog
.control
save all @m.xdut.xmn_flr.m0[id] @m.xdut.xmn_v2i.m0[id] @m.xdut.xmp_s1.m0[id] @m.xdut.xmn_s1.m0[id] @m.xdut.xmn_i1.m0[gm] @m.xdut.xmn_i1.m0[gds] @m.xdut.xmp_i1.m0[gm] @m.xdut.xmp_i1.m0[gds] @m.xdut.xmn_s1.m0[gds] @m.xdut.xmp_s1.m0[gds] @m.xdut.xmn_i1.m0[vth] @m.xdut.xmn_i1.m0[vgs] @m.xdut.xmp_i1.m0[vgs] @m.xdut.xmp_i1.m0[vth]
foreach vc 0.3 0.6 1.65
alter vvc dc = $vc
op
echo VC $vc
print bias_ref xdut.vi xdut.vs xdut.vbp_vco xdut.vbn_vco xdut.r1 xdut.p1 xdut.n1
print @m.xdut.xmn_flr.m0[id] @m.xdut.xmn_v2i.m0[id] @m.xdut.xmp_s1.m0[id] @m.xdut.xmn_s1.m0[id]
print @m.xdut.xmn_i1.m0[gm] @m.xdut.xmn_i1.m0[gds] @m.xdut.xmp_i1.m0[gm] @m.xdut.xmp_i1.m0[gds] @m.xdut.xmn_s1.m0[gds] @m.xdut.xmp_s1.m0[gds] @m.xdut.xmn_i1.m0[vgs] @m.xdut.xmn_i1.m0[vth] @m.xdut.xmp_i1.m0[vgs] @m.xdut.xmp_i1.m0[vth]
end
.endc
.end
