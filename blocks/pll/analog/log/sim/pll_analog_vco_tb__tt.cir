* pll_analog_vco_tb.cir - VCO tuning and output bench (spec.yaml:
* vco_kvco_mhz_per_v, vco_df_dv_min_mhz_per_v, vco_fmin_tt_mhz,
* vco_fmax_tt_mhz, vco_fmax_ff_mhz, vco_out_swing_pct_vdd, vco_out_tr_ns,
* vco_out_tf_ns, vco_out_duty_pct; vco_period_jitter_ps_rms is bounded in the
* sidecar but NOT printed - see JITTER below). Written from spec/ only.
*
* vctrl is forced by vvc; pump inputs low, pll_en = 1, bias_ref floating,
* vco_out into 15 fF. Operating-point-first .tran (no uic) per point.
*
* Sweep: vctrl = 0.3 V .. vdd-0.3 V in 12 equal steps (13 points; point 6 is
* exactly vdd/2). Per point: frequency = 5 / (time of the 6th minus the 1st
* rising vdd/2 crossing after 200 ns), window 1.2 us, so anything above
* ~5 MHz is resolved and a stalled ring prints no frequency at all.
*  - vco_kvco_mhz_per_v    = (f(vdd-0.3) - f(0.3)) / (vdd-0.6), the mean df/dv
*  - vco_df_dv_min_mhz_per_v = min over adjacent points of df/dv
*  - vco_fmin_tt_mhz / vco_fmax_tt_mhz = f(0.3 V) / f(vdd-0.3 V) (bounds at tt)
*  - vco_out_swing_pct_vdd = min over the sweep of (max-min of vco_out after
*    200 ns) / vdd * 100
*  - vco_out_duty_pct      = high time / period at vctrl = vdd/2, vdd/2 threshold
* Extra point vctrl = vdd (the maximum frequency, the prescaler's 333 MHz
* condition): vco_fmax_ff_mhz (bound at ff_m40c_vp10 only) and the 20-80 %
* rise/fall times vco_out_tr_ns / vco_out_tf_ns (bounds at ff_m40c_vp10, tt_27c),
* 5 ps max step.
* If any sweep point fails to oscillate, the sweep-derived measures are not
* printed (sim_measure_missing), never a placeholder.
*
* JITTER: vco_period_jitter_ps_rms needs device noise inside the ring during
* a transient. ngspice-47 has no device-level transient noise (only trnoise/
* trrandom on independent sources), and a bench cannot attach a noise source
* to the ring nodes r1..r5, which are internal to the subckt. The bound is kept
* in the sidecar so the spec measure stays declared; the bench prints nothing
* for it, so sim_tt reports it as a (warning) sim_measure_missing at tt_27c.
* sim_timeout_s: 900

.include '/home/ihsan/.cc/toolchains/iic-osic-tools-2026.09/foss/pdks/gf180mcuD/libs.tech/ngspice/design.spice'
.lib '/home/ihsan/.cc/toolchains/iic-osic-tools-2026.09/foss/pdks/gf180mcuD/libs.tech/ngspice/sm141064.spice' typical
.lib '/home/ihsan/.cc/toolchains/iic-osic-tools-2026.09/foss/pdks/gf180mcuD/libs.tech/ngspice/sm141064.spice' res_typical
.lib '/home/ihsan/.cc/toolchains/iic-osic-tools-2026.09/foss/pdks/gf180mcuD/libs.tech/ngspice/sm141064.spice' mimcap_typical
.include '/home/ihsan/.cc/worktrees/ece298a/pll/blocks/pll/analog/netlist/pll_analog.cir'
.param w_bp='4e-06' l_bp='2e-06' w_b1='2e-06' l_b1='2e-06' w_b2='4e-06' l_b2='1e-06' rb_l=0.00054 w_cpn='2e-05' l_cpn='2e-06' w_cpp='5e-05' l_cpp='2e-06' w_swn='2e-06' w_swp='4e-06' l_sw='5e-07' r1_l=0.000126 c1_w=0.0001 c2_w=3.2e-05 w_v2i='1e-05' l_v2i='1e-06' rv2i_l='2e-05' w_flr='2e-06' l_flr='2e-06' w_v2ip='1e-05' w_v2in='4e-06' l_v2i2='5e-07' w_sp='1e-05' w_sn='4e-06' l_s='5e-07' w_rp='2e-06' w_rn='1e-06' l_r=2.8e-07 w_gp='4e-06' w_gn='4e-06' w_op=1.2e-05 w_on='6e-06'

.temp 27
.param vddp=3.3
.csparam vddp={vddp}
.csparam vmid={vddp/2}
.csparam vhi={vddp-0.3}
.csparam v20={0.2*vddp}
.csparam v80={0.8*vddp}

vdd_src  vdd      0 {vddp}
vss_src  vss      0 0
ven      pll_en   0 {vddp}
vup      pfd_up   0 0
vdn      pfd_dn   0 0
vt0      cp_trim0 0 0
vt1      cp_trim1 0 0
vvc      vctrl    0 0.3
cload    vco_out  0 15f
xdut vco_out pfd_up pfd_dn pll_en cp_trim0 cp_trim1 vctrl bias_ref vdd vss pll_analog

.control
set noaskquit
setplot new
set rp = $curplot
let npt = 12
let dv = (vhi - 0.3)/npt
let k = 0
let ok = 1
let fprev = 0
let dfmin = 1e30
let swmin = 1e30
let f0 = 0
let flast = 0
let duty = 0
while k le npt
  let vc = 0.3 + k*dv
  set kk = "$&k"
  alter vvc dc = $&vc
  tran 20p 1.2u 0 20p
  set tp = $curplot
  let nx = length(time)
  let isrise = (v(vco_out) gt vmid)
  let nx1 = nx - 1
  let nx2 = nx - 2
  let late = time[1,$&nx1] gt 200n
  let nrise = mean((isrise[1,$&nx1] - isrise[0,$&nx2]) gt 0.5 and late)*length(late)
  set gotf = "0"
  if nrise ge 7
    meas tran ta when v(vco_out)=$&vmid rise=1 td=200n
    meas tran tb when v(vco_out)=$&vmid rise=6 td=200n
    meas tran vx max v(vco_out) from=200n to=1.2u
    meas tran vn min v(vco_out) from=200n to=1.2u
    let x = 5/(tb - ta)
    set fks = "$&x"
    let x = vx - vn
    set sws = "$&x"
    set gotf = "1"
    if $kk eq 6
      meas tran dr1 when v(vco_out)=$&vmid rise=2 td=200n
      meas tran df1 when v(vco_out)=$&vmid fall=1 td=$&dr1
      meas tran dr2 when v(vco_out)=$&vmid rise=1 td=$&df1
      let dty = (df1 - dr1)/(dr2 - dr1)*100
      set dtys = "$&dty"
    end
  end
  setplot $rp
  if $gotf eq 1
    let fk = $fks
    let sw = $sws
    if sw lt swmin
      let swmin = sw
    end
    if k eq 0
      let f0 = fk
    else
      let dfdv = (fk - fprev)/dv/1e6
      if dfdv lt dfmin
        let dfmin = dfdv
      end
    end
    if k eq npt
      let flast = fk
    end
    if k eq 6
      let duty = $dtys
    end
    let fprev = fk
  else
    let ok = 0
  end
  destroy $tp
  let k = k + 1
end
let kv = (flast - f0)/(vhi - 0.3)/1e6
let fmn = f0/1e6
let fmx = flast/1e6
let swp = swmin/vddp*100
set okv = "$&ok"
set kvs = "$&kv"
set dfs = "$&dfmin"
set fmns = "$&fmn"
set fmxs = "$&fmx"
set swps = "$&swp"
set dutys = "$&duty"
* --- maximum frequency point: vctrl = vdd, fine step for the edges
alter vvc dc = $&vddp
tran 5p 300n 0 5p
let nx = length(time)
let nx1 = nx - 1
let nx2 = nx - 2
let isrise = (v(vco_out) gt vmid)
let late = time[1,$&nx1] gt 100n
let nrise = mean((isrise[1,$&nx1] - isrise[0,$&nx2]) gt 0.5 and late)*length(late)
set ok2 = "0"
if nrise ge 7
  meas tran ta when v(vco_out)=$&vmid rise=1 td=100n
  meas tran tb when v(vco_out)=$&vmid rise=6 td=100n
  meas tran t20r when v(vco_out)=$&v20 rise=3 td=100n
  meas tran t80r when v(vco_out)=$&v80 rise=1 td=$&t20r
  meas tran t80f when v(vco_out)=$&v80 fall=3 td=100n
  meas tran t20f when v(vco_out)=$&v20 fall=1 td=$&t80f
  let fx = 5/(tb - ta)/1e6
  let trn = (t80r - t20r)*1e9
  let tfn = (t20f - t80f)*1e9
  set fxs = "$&fx"
  set trs = "$&trn"
  set tfs = "$&tfn"
  set ok2 = "1"
end
echo
echo "  Measurements for Transient Analysis (pll_analog_vco_tb, computed in .control)"
if $okv eq 1
  echo "vco_kvco_mhz_per_v = $kvs"
  echo "vco_df_dv_min_mhz_per_v = $dfs"
  echo "vco_fmin_tt_mhz = $fmns"
  echo "vco_fmax_tt_mhz = $fmxs"
  echo "vco_out_swing_pct_vdd = $swps"
  echo "vco_out_duty_pct = $dutys"
end
if $ok2 eq 1
  echo "vco_fmax_ff_mhz = $fxs"
  echo "vco_out_tr_ns = $trs"
  echo "vco_out_tf_ns = $tfs"
end
echo
.endc

.end
