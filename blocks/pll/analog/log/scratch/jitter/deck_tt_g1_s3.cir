.include '/home/ihsan/.cc/toolchains/iic-osic-tools-2026.09/foss/pdks/gf180mcuD/libs.tech/ngspice/design.spice'
.lib '/home/ihsan/.cc/toolchains/iic-osic-tools-2026.09/foss/pdks/gf180mcuD/libs.tech/ngspice/sm141064.spice' typical
.lib '/home/ihsan/.cc/toolchains/iic-osic-tools-2026.09/foss/pdks/gf180mcuD/libs.tech/ngspice/sm141064.spice' res_typical
.lib '/home/ihsan/.cc/toolchains/iic-osic-tools-2026.09/foss/pdks/gf180mcuD/libs.tech/ngspice/sm141064.spice' mimcap_typical
.include '/home/ihsan/.cc/worktrees/ece298a/pll/blocks/pll/analog/netlist/pll_analog.cir'
.param w_bp='4e-06' l_bp='2e-06' w_b1='2e-06' l_b1='2e-06' w_b2='4e-06' l_b2='1e-06' rb_l=0.000366 rbt_l=0.00018 w_cpn='2e-05' l_cpn='2e-06' w_cpp='5e-05' l_cpp='2e-06' w_swn='2e-06' w_swp='4e-06' l_sw='5e-07' r1_l=0.00015 c1_w=0.0001 c2_w=3.2e-05 w_v2i='1e-05' l_v2i='1e-06' rv2i_l=3.5e-05 w_flr='2e-06' l_flr='2e-06' w_v2ip='1e-05' w_v2in='4e-06' l_v2i2='5e-07' w_sp='1e-05' w_sn='4e-06' l_s='5e-07' w_rp='6e-06' w_rn='3e-06' l_r=2.8e-07 w_gp='4e-06' w_gn='4e-06' w_op=1.2e-05 w_on='6e-06' m_buft=4 w_bufp='2e-05' l_bufp='1e-06' w_bufn='1e-05' l_bufn='1e-06' w_bufln='4e-06' w_buflp='8e-06' l_bufl='2e-06' w_cl='4e-05' l_cl='2e-06'

.temp 27
.param vddp=3.3
.csparam vddp={vddp}
.csparam vmid={vddp/2}
.csparam vhi={vddp-0.3}
.csparam v20={0.2*vddp}
.csparam v80={0.8*vddp}

vdd_src  vdd      0 {vddp}
vss_src  vss      0 0
ven      pll_en   0 {vddp}
vup      pfd_up   0 0
vdn      pfd_dn   0 0
vt0      cp_trim0 0 0
vt1      cp_trim1 0 0
vvc      vctrl    0 3.3
cload    vco_out  0 15f
xdut vco_out pfd_up pfd_dn pll_en cp_trim0 cp_trim1 vctrl bias_ref vdd vss pll_analog
ikick 0 xdut.r1 pulse(0 1u 1n 50p 50p 1n 1)
inz1 xdut.r1 0 trnoise(2.509762e-07 5.000e-11 0 0)
inz2 xdut.r2 0 trnoise(2.509762e-07 5.000e-11 0 0)
inz3 xdut.r3 0 trnoise(2.509762e-07 5.000e-11 0 0)
inz4 xdut.r4 0 trnoise(2.509762e-07 5.000e-11 0 0)
inz5 xdut.r5 0 trnoise(2.509762e-07 5.000e-11 0 0)

.control
set rndseed=23
stop when time gt 80n
stop when time gt 130n
stop when time gt 180n
stop when time gt 230n
stop when time gt 280n
stop when time gt 330n
tran 25p 330n 0 25p
wrdata out_tt_g1_s3.txt v(vco_out)
resume
wrdata out_tt_g1_s3.txt v(vco_out)
resume
wrdata out_tt_g1_s3.txt v(vco_out)
resume
wrdata out_tt_g1_s3.txt v(vco_out)
resume
wrdata out_tt_g1_s3.txt v(vco_out)
resume
wrdata out_tt_g1_s3.txt v(vco_out)
resume
wrdata out_tt_g1_s3.txt v(vco_out)
.endc
.end
