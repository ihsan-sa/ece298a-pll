* pll_analog_vco_tb.cir - VCO tuning and output bench (spec.yaml:
* vco_kvco_mhz_per_v, vco_df_dv_min_mhz_per_v, vco_fmin_tt_mhz,
* vco_fmax_tt_mhz, vco_fmax_ff_mhz, vco_out_swing_pct_vdd, vco_out_tr_ns,
* vco_out_tf_ns, vco_out_duty_pct; vco_period_jitter_ps_rms is bounded in the
* sidecar but NOT printed - see JITTER below). Written from spec/ only.
*
* vctrl is forced by vvc; pump inputs low, pll_en = 1, bias_ref floating,
* vco_out into 15 fF. Operating-point-first .tran (no uic) per point: the
* ring starts from its own DC point, so a ring whose DC point is stable
* (a dead VCO) stays stalled, as it would on silicon.
* START-UP KICK: a noiseless op leaves the ring exactly on its symmetric
* balance point (every ring node equal), which is unstable in a live ring but
* which ngspice never leaves without a perturbation (it11: stall at vctrl =
* 0.3 V). ikick injects 1 uA for 1 ns (1 fC, zero at the op) into ring node
* r1 at t = 1 ns of every tran - the stand-in for the device noise that
* starts a real ring. It does not move the bias op point, and a ring whose
* DC point is stable (a dead VCO) still decays back and stays stalled.
*
* Sweep: vctrl = 0.3 V .. vdd-0.3 V in 6 equal steps (7 points; point 3 is
* exactly vdd/2). Per point the frequency comes from an adaptive run ladder
* so a fast ring is not simulated for microseconds (wo-4: 13 points x 1.2 us
* at a 20 ps step timed out at 900 s):
*   stage 0: tran max step 20 ps to 25 ns,   crossings after 4 ns
*   stage 1: tran max step 20 ps to 60 ns,   crossings after 4 ns
*   stage 2: tran max step 250 ps to 400 ns, crossings after 20 ns
* The first stage with >= 6 rising vdd/2 crossings after its settle time
* gives f = 5 / (t(rise 6) - t(rise 1)), the mean of 5 periods (stage 0
* resolves f >~ 290 MHz, stage 1 f >~ 110 MHz, stage 2 f >~ 16 MHz). Stage 1
* exists because a 250 ps step misreads a fast ring: at tt_m40c_vm10,
* vctrl = 2.275 V it read 152 MHz for a ring that runs at 223 MHz (09-29
* sim_pvt, a false negative df/dv). If stage 2 still has fewer,
* f = (n-1) / (t(rise n) - t(rise 1)) over the n >= 2 rises it has, and
* f = 0 when n < 2 (the ring is stalled: below ~3 MHz). A
* stalled point is a real measured value, never skipped: every sweep measure
* below is printed at every corner so a dead or non-monotonic VCO shows as a
* bound failure, not a missing measure.
*  - vco_kvco_mhz_per_v    = (f(vdd-0.3) - f(0.3)) / (vdd-0.6), the mean df/dv
*  - vco_df_dv_min_mhz_per_v = min over adjacent points of df/dv
*  - vco_fmin_tt_mhz / vco_fmax_tt_mhz = f(0.3 V) / f(vdd-0.3 V) (bounds at tt)
*  - vco_out_swing_pct_vdd = min over the sweep of (max-min of vco_out after
*    the accepted stage's settle time) / vdd * 100
*  - vco_out_duty_pct      = high time / period at vctrl = vdd/2, vdd/2
*    threshold (rise 1 -> next fall -> next rise after settle). With fewer
*    than 2 rises it is the fraction of time vco_out sits above vdd/2 after
*    settle (0 or 100 for a stuck output) - the limit of the same ratio.
* Extra point vctrl = vdd (the maximum frequency, the prescaler's 333 MHz
* condition): vco_fmax_ff_mhz (bound at ff_m40c_vp10 only) from the same
* ladder, and the 20-80 % rise/fall times vco_out_tr_ns / vco_out_tf_ns
* (bounds at ff_m40c_vp10, tt_27c) from a second run at a 5 ps max step
* (rise 2 / fall 2 after 4 ns). A vdd point with no edges prints no tr/tf:
* a rise time of an output that never rises does not exist.
*
* JITTER: vco_period_jitter_ps_rms needs device noise inside the ring during
* a transient. ngspice-47 has no device-level transient noise (only trnoise/
* trrandom on independent sources), and a bench cannot attach a noise source
* to the ring nodes r1..r5, which are internal to the subckt. The bound is kept
* in the sidecar so the spec measure stays declared; the bench prints nothing
* for it, so sim_tt reports it as a (warning) sim_measure_missing at tt_27c.
* sim_timeout_s: 1800

.include '/home/ihsan/.cc/toolchains/iic-osic-tools-2026.09/foss/pdks/gf180mcuD/libs.tech/ngspice/design.spice'
.lib '/home/ihsan/.cc/toolchains/iic-osic-tools-2026.09/foss/pdks/gf180mcuD/libs.tech/ngspice/sm141064.spice' ff
.lib '/home/ihsan/.cc/toolchains/iic-osic-tools-2026.09/foss/pdks/gf180mcuD/libs.tech/ngspice/sm141064.spice' res_typical
.lib '/home/ihsan/.cc/toolchains/iic-osic-tools-2026.09/foss/pdks/gf180mcuD/libs.tech/ngspice/sm141064.spice' mimcap_typical
.include '/home/ihsan/.cc/worktrees/ece298a/pll/blocks/pll/analog/netlist/pll_analog.cir'
.param w_bp='4e-06' l_bp='2e-06' w_b1='2e-06' l_b1='2e-06' w_b2='4e-06' l_b2='1e-06' rb_l=0.000366 rbt_l=0.00018 w_cpn='2e-05' l_cpn='2e-06' w_cpp='5e-05' l_cpp='2e-06' w_swn='2e-06' w_swp='4e-06' l_sw='5e-07' r1_l=0.000126 c1_w=0.0001 c2_w=3.2e-05 w_v2i='1e-05' l_v2i='1e-06' rv2i_l=3.5e-05 w_flr='2e-06' l_flr='2e-06' w_v2ip='1e-05' w_v2in='4e-06' l_v2i2='5e-07' w_sp='1e-05' w_sn='4e-06' l_s='5e-07' w_rp='6e-06' w_rn='3e-06' l_r=2.8e-07 w_gp='4e-06' w_gn='4e-06' w_op=1.2e-05 w_on='6e-06' m_buft=4 w_bufp='2e-05' l_bufp='1e-06' w_bufn='1e-05' l_bufn='1e-06' w_bufln='4e-06' w_buflp='8e-06' l_bufl='2e-06' w_cl='4e-05' l_cl='2e-06'

.temp -40
.param vddp=3.63
.csparam vddp={vddp}
.csparam vmid={vddp/2}
.csparam vhi={vddp-0.3}
.csparam v20={0.2*vddp}
.csparam v80={0.8*vddp}

vdd_src  vdd      0 {vddp}
vss_src  vss      0 0
ven      pll_en   0 {vddp}
vup      pfd_up   0 0
vdn      pfd_dn   0 0
vt0      cp_trim0 0 0
vt1      cp_trim1 0 0
vvc      vctrl    0 0.3
cload    vco_out  0 15f
xdut vco_out pfd_up pfd_dn pll_en cp_trim0 cp_trim1 vctrl bias_ref vdd vss pll_analog
ikick    0        xdut.r1 pulse(0 1u 1n 50p 50p 1n 1)

.control
set noaskquit
alter vvc dc = 3.63
tran 20p 80n 0 20p
meas tran ta when v(vco_out)=1.815 rise=1 td=20n
meas tran tb when v(vco_out)=1.815 rise=11 td=20n
.endc
.end
