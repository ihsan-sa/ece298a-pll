* pll_analog_ol_tb.cir - open-loop gain bench, pump + filter + VCO with an
* ideal 1/(P*N) divider (spec.yaml: ol_pm_pn16_nopad_deg,
* ol_pm_pn16_pad5p_deg, ol_fc_pn16_nopad_khz, ol_pm_pn8_nopad_deg,
* ol_pm_pn40_nopad_deg). Written from spec/ only. All five are scored at
* tt_27c only, so the bench computes and prints them only at that corner
* (process typical, 27 C, vdd = spec supply 3.3 V) and prints nothing
* elsewhere - no placeholder values.
*
* H(s) = (Icp/2pi) * Z(s) * (2pi Kvco) / (s P N) = Icp Kvco Z(j2pi f) / (j2pi f P N)
* with every factor taken from the DUT itself, cp_trim = 00, pll_en = 1:
*  - Icp   = mean of the UP and DN pump currents at vctrl = vdd/2 (DC op)
*  - Kvco  = (f(vdd-0.3) - f(0.3)) / (vdd-0.6) in Hz/V (mean slope, the same
*            definition as vco_kvco_mhz_per_v), from two transients
*  - Z(s)  = v(vctrl) for a 1 A AC current into vctrl with both pump inputs
*            low: the cell's own R1/C1/C2, V2I gate and pump off-impedance
*            (plus 5 pF for the pad case). vctrl's DC point (vdd/2) is set
*            through a 1 GH feed inductor, an open circuit at 1 kHz and up.
* fc = |H| = 1 crossing; PM = 180 + arg H(fc) = 90 + arg Z(fc) (deg).
* cp_trim stays 00 at every P*N (spec.md's default condition; spec.yaml does
* not name another code for P*N = 40).
* sim_timeout_s: 600

.include '{{PDK}}/libs.tech/ngspice/design.spice'
.lib '{{PDK}}/libs.tech/ngspice/sm141064.spice' {{CORNER}}
.lib '{{PDK}}/libs.tech/ngspice/sm141064.spice' {{RES_CORNER}}
.lib '{{PDK}}/libs.tech/ngspice/sm141064.spice' mimcap_{{CORNER}}
.include '{{NETLIST}}'
{{SIZING}}

.temp {{TEMP_C}}
.param vddp={{VDD}}
.param tempp={{TEMP_C}}
.param p_typical=1 p_ss=2 p_ff=3
.csparam procn={p_{{CORNER}}}
.csparam tempc={tempp}
.csparam vddp={vddp}
.csparam vmid={vddp/2}
.csparam vhi={vddp-0.3}

vdd_src  vdd      0 {vddp}
vss_src  vss      0 0
ven      pll_en   0 {vddp}
vup      pfd_up   0 0
vdn      pfd_dn   0 0
vt0      cp_trim0 0 0
vt1      cp_trim1 0 0
vvc      vfeed    0 {vddp/2}
lfeed    vfeed    vctrl 1e9
cpad     vctrl    0 1e-18
iac      0        vctrl dc 0 ac 1
cload    vco_out  0 15f
xdut vco_out pfd_up pfd_dn pll_en cp_trim0 cp_trim1 vctrl bias_ref vdd vss pll_analog

.control
set noaskquit
set istt = "0"
if (procn eq 1) and (tempc eq 27) and (abs(vddp - 3.3) lt 0.01)
  set istt = "1"
end
set okall = "0"
if $istt eq 1
  * --- Icp at vdd/2, code 00
  alter vup dc = $&vddp
  op
  let x = i(vvc)
  set iup = "$&x"
  alter vup dc = 0
  alter vdn dc = $&vddp
  op
  let x = (-i(vvc) + $iup)/2
  set icp = "$&x"
  alter vdn dc = 0
  * --- Kvco (mean slope over the tuning range)
  set fok = "1"
  set fl = "0"
  foreach vc 0.3 $&vhi
    alter vvc dc = $vc
    tran 20p 1.2u 0 20p
    let nx = length(time)
    let nx1 = nx - 1
    let nx2 = nx - 2
    let isrise = (v(vco_out) gt vmid)
    let late = time[1,$&nx1] gt 200n
    let nrise = mean((isrise[1,$&nx1] - isrise[0,$&nx2]) gt 0.5 and late)*length(late)
    if nrise ge 7
      meas tran ta when v(vco_out)=$&vmid rise=1 td=200n
      meas tran tb when v(vco_out)=$&vmid rise=6 td=200n
      let x = 5/(tb - ta)
      set fh = "$&x"
      if $fl eq 0
        set fl = "$&x"
      end
    else
      set fok = "0"
    end
    destroy $curplot
  end
  if $fok eq 1
    let x = ($fh - $fl)/(vhi - 0.3)
    set kv = "$&x"
    alter vvc dc = $&vmid
    * --- Z(s) at vctrl, no pad
    ac dec 50 1k 100meg
    let zp = 180/pi*ph(v(vctrl))
    let fr = real(frequency)
    let g = $icp * $kv * mag(v(vctrl)) / (2*pi*fr)
    let h16 = g/16
    let h8 = g/8
    let h40 = g/40
    meas ac fc16 when h16=1 fall=1
    meas ac fc8 when h8=1 fall=1
    meas ac fc40 when h40=1 fall=1
    meas ac pz16 find zp at=$&fc16
    meas ac pz8 find zp at=$&fc8
    meas ac pz40 find zp at=$&fc40
    let x = 90 + pz16
    set pm16 = "$&x"
    let x = 90 + pz8
    set pm8 = "$&x"
    let x = 90 + pz40
    set pm40 = "$&x"
    let x = fc16/1e3
    set fc16k = "$&x"
    * --- same with 5 pF of pad on vctrl
    alter cpad = 5e-12
    ac dec 50 1k 100meg
    let zp = 180/pi*ph(v(vctrl))
    let fr = real(frequency)
    let h16 = $icp * $kv * mag(v(vctrl)) / (2*pi*fr*16)
    meas ac fc16p when h16=1 fall=1
    meas ac pz16p find zp at=$&fc16p
    let x = 90 + pz16p
    set pm16p = "$&x"
    set okall = "1"
  end
end
echo
echo "  Measurements for AC Analysis (pll_analog_ol_tb, computed in .control)"
if $okall eq 1
  echo "ol_pm_pn16_nopad_deg = $pm16"
  echo "ol_pm_pn16_pad5p_deg = $pm16p"
  echo "ol_fc_pn16_nopad_khz = $fc16k"
  echo "ol_pm_pn8_nopad_deg = $pm8"
  echo "ol_pm_pn40_nopad_deg = $pm40"
end
echo
.endc

.end
