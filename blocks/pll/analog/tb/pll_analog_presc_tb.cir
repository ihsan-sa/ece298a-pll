* pll_analog_presc_tb.cir - prescaler-drive bench (spec.yaml:
* presc_div2_ratio, scored at ff_m40c_vp10 only, so computed and printed only
* at that corner: process ff, -40 C, vdd above nominal). Written from spec/.
*
* vco_out drives the first /2 stage of the digital prescaler: a
* gf180mcu_fd_sc_mcu7t5v0__dffq_1 clocked by vco_out with Q fed back to D
* through gf180mcu_fd_sc_mcu7t5v0__inv_1 (toggle), plus one inv_1 input as
* the "one buffer" spec.md puts on vco_out. vctrl = vdd, the maximum VCO
* frequency (the 333 MHz condition). Cells run from the same vdd.
* presc_div2_ratio = f(Q) / (f(vco_out)/2) = 2*T_vco/T_q, with T_vco the mean
* of 20 vco_out periods and T_q the mean of the 10 Q periods spanning them,
* both from rising vdd/2 crossings after 100 ns.
*
* Cell netlist: the PDK's own libs.ref/.../spice/gf180mcu_fd_sc_mcu7t5v0.spice
* (transistor-level cell netlist, NOT a parasitic-extracted view; spec.md
* says "extracted" and none exists under the PDK). Its devices are
* nfet_05v0/pfet_05v0 subckt calls, which sm141064.spice (the model file every
* bench here uses) does not define; the two .subckt below map them to the
* nfet_06v0/pfet_06v0 models exactly as the PDK's own sm141064.ngspice
* wrappers do, minus the mismatch terms (sw_stat_mismatch = 0 anyway).
* sim_timeout_s: 600

.include '{{PDK}}/libs.tech/ngspice/design.spice'
.lib '{{PDK}}/libs.tech/ngspice/sm141064.spice' {{CORNER}}
.lib '{{PDK}}/libs.tech/ngspice/sm141064.spice' {{RES_CORNER}}
.lib '{{PDK}}/libs.tech/ngspice/sm141064.spice' mimcap_{{CORNER}}
.include '{{NETLIST}}'
.include '{{PDK}}/libs.ref/gf180mcu_fd_sc_mcu7t5v0/spice/gf180mcu_fd_sc_mcu7t5v0.spice'
{{SIZING}}

.subckt nfet_05v0 d g s b w=1e-6 l=6e-7 nf=1 m=1
m0 d g s b nfet_06v0 w={w} l={l} nf={nf} m={m}
.ends nfet_05v0
.subckt pfet_05v0 d g s b w=1e-5 l=5e-7 nf=1 m=1
m0 d g s b pfet_06v0 w={w} l={l} nf={nf} m={m}
.ends pfet_05v0

.temp {{TEMP_C}}
.param vddp={{VDD}}
.param tempp={{TEMP_C}}
.param p_typical=1 p_ss=2 p_ff=3
.csparam procn={p_{{CORNER}}}
.csparam tempc={tempp}
.csparam vddp={vddp}
.csparam vmid={vddp/2}

vdd_src  vdd      0 {vddp}
vss_src  vss      0 0
ven      pll_en   0 {vddp}
vup      pfd_up   0 0
vdn      pfd_dn   0 0
vt0      cp_trim0 0 0
vt1      cp_trim1 0 0
vvc      vctrl    0 {vddp}
xdut vco_out pfd_up pfd_dn pll_en cp_trim0 cp_trim1 vctrl bias_ref vdd vss pll_analog
xdff  d   vco_out q   vdd vdd vss vss gf180mcu_fd_sc_mcu7t5v0__dffq_1
xtog  q   d           vdd vdd vss vss gf180mcu_fd_sc_mcu7t5v0__inv_1
xbuf  vco_out nbuf    vdd vdd vss vss gf180mcu_fd_sc_mcu7t5v0__inv_1

.control
set noaskquit
set okp = "0"
if (procn eq 3) and (tempc eq -40) and (vddp gt 3.4)
  tran 5p 300n 0 5p
  let nx = length(time)
  let nx1 = nx - 1
  let nx2 = nx - 2
  let late = time[1,$&nx1] gt 100n
  let hv = (v(vco_out) gt vmid)
  let hq = (v(q) gt vmid)
  let nv = mean(((hv[1,$&nx1] - hv[0,$&nx2]) gt 0.5) and late)*length(late)
  let nq = mean(((hq[1,$&nx1] - hq[0,$&nx2]) gt 0.5) and late)*length(late)
  if (nv ge 22) and (nq ge 11)
    meas tran va when v(vco_out)=$&vmid rise=1 td=100n
    meas tran vb when v(vco_out)=$&vmid rise=21 td=100n
    meas tran qa when v(q)=$&vmid rise=1 td=$&va
    meas tran qb when v(q)=$&vmid rise=11 td=$&va
    let x = 2*((vb - va)/20)/((qb - qa)/10)
    set rat = "$&x"
    set okp = "1"
  else
    let x = 2*nq/nv
    set rat = "$&x"
    set okp = "1"
  end
end
echo
echo "  Measurements for Transient Analysis (pll_analog_presc_tb, computed in .control)"
if $okp eq 1
  echo "presc_div2_ratio = $rat"
end
echo
.endc

.end
